// two_stage_ota.cir -- Two-Stage Miller OTA (Spectre native syntax)
simulator lang=spectre insensitive=yes

include "/PDKS/TSMC28nm/models/spectre/toplevel.scs" section=top_tt

parameters Wbias=5u Lbias=200n m_tail_unit=2 ratio_load_tail=2
parameters m_load_unit=m_tail_unit*ratio_load_tail
parameters Wdiff=10u Ldiff=60n
parameters Wmirr=5u Lmirr=100n Wcs=20u
parameters Cc=500f Rz=1k

subckt two_stage_ota (vip vin vout ibias vdd vss)
// Bias generator: external current into diode-connected NMOS
Mbias (ibias ibias vss vss) nch_mac w=Wbias l=Lbias nf=1
// First stage: NMOS differential pair
Mdiff1 (n_mirr vin n_tail vss) nch_mac w=Wdiff l=Ldiff nf=1
Mdiff2 (n_s1 vip n_tail vss) nch_mac w=Wdiff l=Ldiff nf=1
// First stage: PMOS current mirror load
Mmirr1 (n_mirr n_mirr vdd vdd) pch_mac w=Wmirr l=Lmirr nf=1
Mmirr2 (n_s1 n_mirr vdd vdd) pch_mac w=Wmirr l=Lmirr nf=1
// First stage: NMOS tail current source
Mtail (n_tail ibias vss vss) nch_mac w=Wbias l=Lbias nf=1 m=m_tail_unit
// Second stage
Mcs (vout n_s1 vdd vdd) pch_mac w=Wcs l=Lbias nf=1
Mload (vout ibias vss vss) nch_mac w=Wbias l=Lbias nf=1 m=m_load_unit
// Miller compensation
Rz (n_s1 n_rz) resistor r=Rz
Cc (n_rz vout) capacitor c=Cc
ends two_stage_ota
