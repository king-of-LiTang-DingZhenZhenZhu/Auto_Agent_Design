// Spectre netlist — Five-Transistor OTA
// TSMC 28nm CLN28HPC+ | VDD=1.1V | Vbias=500mV

simulator lang=spectre insensitive=yes

include "/PDKS/TSMC28nm/models/spectre/toplevel.scs" section=top_tt

// ------- 参数 -------
parameters VDD=1.1 VBIAS=0.5
parameters Wcm=2u  Lcm=100n
parameters Wdp=3u  Ldp=100n
parameters Wtail=3u Ltail=200n

// ------- 电源 & 偏置 -------
VDD   (vdd 0)   vsource type=dc dc=VDD
VBIAS (vbias 0) vsource type=dc dc=VBIAS
VIP   (vip 0)   vsource type=dc dc=0.55 mag=0.5
VIN   (vin 0)   vsource type=dc dc=0.55 mag=-0.5

// ------- 晶体管 -------
M5 (tail vbias vdd  vdd)  pch_mac w=Wtail l=Ltail nf=1
M1 (lout vip   tail tail) pch_mac w=Wdp   l=Ldp   nf=1
M2 (vout vin   tail tail) pch_mac w=Wdp   l=Ldp   nf=1
M3 (lout lout  0    0)    nch_mac w=Wcm   l=Lcm   nf=1
M4 (vout lout  0    0)    nch_mac w=Wcm   l=Lcm   nf=1

// ------- 负载电容 -------
CL (vout 0) capacitor c=1p

// ------- 仿真 -------
op1 dc oppoint=rawfile

ac1 ac start=1k stop=10G dec=100

save vout
